* Hard square gate at the warble rate — the parts-trade path
.include models.inc
.include schmitt_osc.sub
.include wien_osc.sub
.include tone_front.sub

Vcc vcc 0 12
Vee vee 0 -12
Vcad cad 0 5

Xfront audio cad vcc vee tone_front GATE=2 LEVEL=0.18

.option method=gear reltol=1e-3 abstol=1n rshunt=1e12
.control
  tran 20u 400m uic
  set filetype=ascii
  wrdata out/hard time audio
  quit
.endc
.end
